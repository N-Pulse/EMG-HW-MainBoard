| IBIS file stm32wba63_a65_ufqfpn48_smps.ibs
[IBIS ver] 4.2
[File name] stm32wba63_a65_ufqfpn48_smps.ibs
[File Rev] 2.0
[Date] 17-02-2025
[Source] Data Created at STMicroelectronics
[Notes]  File originated from ELDO simulations.
[Disclaimer]  This information is for modeling purpose only and is
   not guaranted. The information is subject to change without
   notice.
[Copyright] Copyright 2025 STMicroelectronics Inc.
|   Component stm32wba63_a65_ufqfpn48_smps
[Component] stm32wba63_a65_ufqfpn48_smps
[Manufacturer] STMicroelectronics
[Package]
| variable   typ   min   max
R_pkg  0  NA  NA
L_pkg  0  NA  NA
C_pkg  0  NA  NA
[Pin]   signal_name   model_name
0  VSS  gnd
1  VSSSMPS  nc
2  VDDSMPS  nc
3  VLXSMPS  nc
4  PB12  io8_ft_100m
5  PA8  io8_ft_100m
6  PA7  io8_ft_100m_i2c_v33
7  PA6  io8_ft_100m_i2c
8  VDDA  nc
9  PA5  io8_ft_100m
10  PA2  io8_ft_100m_v33
11  VDD  power
12  PA1  io8_ft_100m
13  PA0  io8_ft_100m
14  PB9  io8_ft_100m
15  PB8  io8_ft_100m
16  PC15-OSC32_OUT  io_ft_tamp
17  PC14-OSC32_IN  io_ft_tamp
18  PC13  io8_ft_100m_v33
19  PB7  io8_ft_100m
20  PB6  io8_ft_100m
21  PB5  io8_ft_100m
22  VDD  power
23  PB4  io8_ft_100m
24  PB3  io8_ft_100m_i2c
25  PA15  io8_ft_100m_i2c
26  PA14  io8_ft_100m_v33
27  PA13  io8_ft_100m
28  PA12  io8_ft_100m
29  PA11  io8_ft_100m
30  PB2  io8_ft_100m_i2c_v33
31  PB1  io8_ft_100m_i2c
32  PB0  io8_ft_100m
33  PB15  io8_ft_100m
34  PH3  io8_ft_100m_v33
35  VDD  power
36  NRST  ioreset_v33
37  RF  nc
38  VDDHPA  nc
39  VDDANA  nc
40  VDDRF  nc
41  OSC_OUT  nc
42  OSC_IN  nc
43  VDDRFPA  nc
44  VDD  power
45  VDD11  nc
46  PA10  io8_ft_100m
47  PA9  io8_ft_100m
48  PB14  io8_ft_100m_i2c
[Package Model]   4b0-ufqfpn-7x7-48-no-usb-240917
[Pin Mapping]   pulldown_ref   pullup_ref   | Comment
0  gndio  nc
1  nc  nc
2  nc  nc
3  nc  nc
4  gndio  vddio
5  gndio  vddio
6  gndio  vddio
7  gndio  vddio
8  nc  nc
9  gndio  vddio
10  gndio  vddio
11  nc  vddio
12  gndio  vddio
13  gndio  vddio
14  gndio  vddio
15  gndio  vddio
16  gndio  vddio
17  gndio  vddio
18  gndio  vddio
19  gndio  vddio
20  gndio  vddio
21  gndio  vddio
22  nc  vddio
23  gndio  vddio
24  gndio  vddio
25  gndio  vddio
26  gndio  vddio
27  gndio  vddio
28  gndio  vddio
29  gndio  vddio
30  gndio  vddio
31  gndio  vddio
32  gndio  vddio
33  gndio  vddio
34  gndio  vddio
35  nc  vddio
36  gndio  vddio
37  nc  nc
38  nc  nc
39  nc  nc
40  nc  nc
41  nc  nc
42  nc  nc
43  nc  nc
44  nc  vddio
45  nc  nc
46  gndio  vddio
47  gndio  vddio
48  gndio  vddio
[Model Selector] io8_ft_100m
io8_ft_100m_ls_1v2  "GPIO 100MHz - 5V tolerant - low speed - 1.2V range"
io8_ft_100m_ls_1v8  "GPIO 100MHz - 5V tolerant - low speed - 1.8V range"
io8_ft_100m_ls_3v3  "GPIO 100MHz - 5V tolerant - low speed - 3.3V range"
io8_ft_100m_ms_1v2  "GPIO 100MHz - 5V tolerant - med speed - 1.2V range"
io8_ft_100m_ms_1v8  "GPIO 100MHz - 5V tolerant - med speed - 1.8V range"
io8_ft_100m_ms_3v3  "GPIO 100MHz - 5V tolerant - med speed - 3.3V range"
io8_ft_100m_fs_1v2  "GPIO 100MHz - 5V tolerant - fast speed - 1.2V range"
io8_ft_100m_fs_1v8  "GPIO 100MHz - 5V tolerant - fast speed - 1.8V range"
io8_ft_100m_fs_3v3  "GPIO 100MHz - 5V tolerant - fast speed - 3.3V range"
io8_ft_100m_hs_1v2  "GPIO 100MHz - 5V tolerant - high speed - 1.2V range"
io8_ft_100m_hs_1v8  "GPIO 100MHz - 5V tolerant - high speed - 1.8V range"
io8_ft_100m_hs_3v3  "GPIO 100MHz - 5V tolerant - high speed - 3.3V range"
[Model Selector] io8_ft_100m_i2c
io8_ft_100m_ls_1v2  "GPIO 100MHz - 5V tolerant - low speed - 1.2V range"
io8_ft_100m_ls_1v8  "GPIO 100MHz - 5V tolerant - low speed - 1.8V range"
io8_ft_100m_ls_3v3  "GPIO 100MHz - 5V tolerant - low speed - 3.3V range"
io8_ft_100m_ms_1v2  "GPIO 100MHz - 5V tolerant - med speed - 1.2V range"
io8_ft_100m_ms_1v8  "GPIO 100MHz - 5V tolerant - med speed - 1.8V range"
io8_ft_100m_ms_3v3  "GPIO 100MHz - 5V tolerant - med speed - 3.3V range"
io8_ft_100m_fs_1v2  "GPIO 100MHz - 5V tolerant - fast speed - 1.2V range"
io8_ft_100m_fs_1v8  "GPIO 100MHz - 5V tolerant - fast speed - 1.8V range"
io8_ft_100m_fs_3v3  "GPIO 100MHz - 5V tolerant - fast speed - 3.3V range"
io8_ft_100m_hs_1v2  "GPIO 100MHz - 5V tolerant - high speed - 1.2V range"
io8_ft_100m_hs_1v8  "GPIO 100MHz - 5V tolerant - high speed - 1.8V range"
io8_ft_100m_hs_3v3  "GPIO 100MHz - 5V tolerant - high speed - 3.3V range"
io8_ft_100m_i2c_ls_1v2  "GPIO 100MHz with I2C open-drain - 5V tolerant - low speed - 1.2V range"
io8_ft_100m_i2c_ls_1v8  "GPIO 100MHz with I2C open-drain - 5V tolerant - low speed - 1.8V range"
io8_ft_100m_i2c_ls_3v3  "GPIO 100MHz with I2C open-drain - 5V tolerant - low speed - 3.3V range"
io8_ft_100m_i2c_ms_1v2  "GPIO 100MHz with I2C open-drain - 5V tolerant - med speed - 1.2V range"
io8_ft_100m_i2c_ms_1v8  "GPIO 100MHz with I2C open-drain - 5V tolerant - med speed - 1.8V range"
io8_ft_100m_i2c_ms_3v3  "GPIO 100MHz with I2C open-drain - 5V tolerant - med speed - 3.3V range"
io8_ft_100m_i2c_fs_1v2  "GPIO 100MHz with I2C open-drain - 5V tolerant - fast speed - 1.2V range"
io8_ft_100m_i2c_fs_1v8  "GPIO 100MHz with I2C open-drain - 5V tolerant - fast speed - 1.8V range"
io8_ft_100m_i2c_fs_3v3  "GPIO 100MHz with I2C open-drain - 5V tolerant - fast speed - 3.3V range"
io8_ft_100m_i2c_hs_1v2  "GPIO 100MHz with I2C open-drain - 5V tolerant - high speed - 1.2V range"
io8_ft_100m_i2c_hs_1v8  "GPIO 100MHz with I2C open-drain - 5V tolerant - high speed - 1.8V range"
io8_ft_100m_i2c_hs_3v3  "GPIO 100MHz with I2C open-drain - 5V tolerant - high speed - 3.3V range"
io8_ft_100m_i2c_fmp_3v3  "GPIO 100MHz with I2C fm+ open-drain - 5V tolerant - low speed - 3.3V range"
io8_ft_100m_i2c_fmp_1v8  "GPIO 100MHz with I2C fm+ open-drain - 5V tolerant - low speed - 1.8V range"
io8_ft_100m_i2c_fmp_1v2  "GPIO 100MHz with I2C fm+ open-drain - 5V tolerant - low speed - 1.2V range"
[Model Selector] io8_ft_100m_i2c_v33
io8_ft_100m_v33_ls_1v2  "GPIO_V33 100MHz - 5V tolerant - low speed - 1.2V range"
io8_ft_100m_v33_ls_1v8  "GPIO_V33 100MHz - 5V tolerant - low speed - 1.8V range"
io8_ft_100m_v33_ls_3v3  "GPIO_V33 100MHz - 5V tolerant - low speed - 3.3V range"
io8_ft_100m_v33_ms_1v2  "GPIO_V33 100MHz - 5V tolerant - med speed - 1.2V range"
io8_ft_100m_v33_ms_1v8  "GPIO_V33 100MHz - 5V tolerant - med speed - 1.8V range"
io8_ft_100m_v33_ms_3v3  "GPIO_V33 100MHz - 5V tolerant - med speed - 3.3V range"
io8_ft_100m_v33_fs_1v2  "GPIO_V33 100MHz - 5V tolerant - fast speed - 1.2V range"
io8_ft_100m_v33_fs_1v8  "GPIO_V33 100MHz - 5V tolerant - fast speed - 1.8V range"
io8_ft_100m_v33_fs_3v3  "GPIO_V33 100MHz - 5V tolerant - fast speed - 3.3V range"
io8_ft_100m_v33_hs_1v2  "GPIO_V33 100MHz - 5V tolerant - high speed - 1.2V range"
io8_ft_100m_v33_hs_1v8  "GPIO_V33 100MHz - 5V tolerant - high speed - 1.8V range"
io8_ft_100m_v33_hs_3v3  "GPIO_V33 100MHz - 5V tolerant - high speed - 3.3V range"
io8_ft_100m_i2c_v33_ls_1v2  "GPIO_V33 100MHz with I2C open-drain - 5V tolerant - low speed - 1.2V range"
io8_ft_100m_i2c_v33_ls_1v8  "GPIO_V33 100MHz with I2C open-drain - 5V tolerant - low speed - 1.8V range"
io8_ft_100m_i2c_v33_ls_3v3  "GPIO_V33 100MHz with I2C open-drain - 5V tolerant - low speed - 3.3V range"
io8_ft_100m_i2c_v33_ms_1v2  "GPIO_V33 100MHz with I2C open-drain - 5V tolerant - med speed - 1.2V range"
io8_ft_100m_i2c_v33_ms_1v8  "GPIO_V33 100MHz with I2C open-drain - 5V tolerant - med speed - 1.8V range"
io8_ft_100m_i2c_v33_ms_3v3  "GPIO_V33 100MHz with I2C open-drain - 5V tolerant - med speed - 3.3V range"
io8_ft_100m_i2c_v33_fs_1v2  "GPIO_V33 100MHz with I2C open-drain - 5V tolerant - fast speed - 1.2V range"
io8_ft_100m_i2c_v33_fs_1v8  "GPIO_V33 100MHz with I2C open-drain - 5V tolerant - fast speed - 1.8V range"
io8_ft_100m_i2c_v33_fs_3v3  "GPIO_V33 100MHz with I2C open-drain - 5V tolerant - fast speed - 3.3V range"
io8_ft_100m_i2c_v33_hs_1v2  "GPIO_V33 100MHz with I2C open-drain - 5V tolerant - high speed - 1.2V range"
io8_ft_100m_i2c_v33_hs_1v8  "GPIO_V33 100MHz with I2C open-drain - 5V tolerant - high speed - 1.8V range"
io8_ft_100m_i2c_v33_hs_3v3  "GPIO_V33 100MHz with I2C open-drain - 5V tolerant - high speed - 3.3V range"
io8_ft_100m_i2c_fmp_v33_1v2  "GPIO_V33 100MHz with I2C fm+ open-drain - 5V tolerant - low speed - 1.2V range"
io8_ft_100m_i2c_fmp_v33_1v8  "GPIO_V33 100MHz with I2C fm+ open-drain - 5V tolerant - low speed - 1.8V range"
io8_ft_100m_i2c_fmp_v33_3v3  "GPIO_V33 100MHz with I2C fm+ open-drain - 5V tolerant - low speed - 3.3V range"
[Model Selector] io8_ft_100m_v33
io8_ft_100m_v33_ls_1v2  "GPIO_V33 100MHz - 5V tolerant - low speed - 1.2V range"
io8_ft_100m_v33_ls_1v8  "GPIO_V33 100MHz - 5V tolerant - low speed - 1.8V range"
io8_ft_100m_v33_ls_3v3  "GPIO_V33 100MHz - 5V tolerant - low speed - 3.3V range"
io8_ft_100m_v33_ms_1v2  "GPIO_V33 100MHz - 5V tolerant - med speed - 1.2V range"
io8_ft_100m_v33_ms_1v8  "GPIO_V33 100MHz - 5V tolerant - med speed - 1.8V range"
io8_ft_100m_v33_ms_3v3  "GPIO_V33 100MHz - 5V tolerant - med speed - 3.3V range"
io8_ft_100m_v33_fs_1v2  "GPIO_V33 100MHz - 5V tolerant - fast speed - 1.2V range"
io8_ft_100m_v33_fs_1v8  "GPIO_V33 100MHz - 5V tolerant - fast speed - 1.8V range"
io8_ft_100m_v33_fs_3v3  "GPIO_V33 100MHz - 5V tolerant - fast speed - 3.3V range"
io8_ft_100m_v33_hs_1v2  "GPIO_V33 100MHz - 5V tolerant - high speed - 1.2V range"
io8_ft_100m_v33_hs_1v8  "GPIO_V33 100MHz - 5V tolerant - high speed - 1.8V range"
io8_ft_100m_v33_hs_3v3  "GPIO_V33 100MHz - 5V tolerant - high speed - 3.3V range"
[Model Selector] io_ft_tamp
io_ft_tamp_ls_1v2 "io8_ft tamp low speed @ 1.2V"
io_ft_tamp_ls_1v8 "io8_ft tamp low speed @ 1.8V"
io_ft_tamp_ls_3v3 "io8_ft tamp low speed @ 3.3V"
io_ft_tamp_ms_1v2 "io8_ft tamp med speed @ 1.2V"
io_ft_tamp_ms_1v8 "io8_ft tamp med speed @ 1.8V"
io_ft_tamp_ms_3v3 "io8_ft tamp med speed @ 3.3V"
io_ft_tamp_fs_1v2 "io8_ft tamp fast speed @ 1.2V"
io_ft_tamp_fs_1v8 "io8_ft tamp fast speed @ 1.8V"
io_ft_tamp_fs_3v3 "io8_ft tamp fast speed @ 3.3V"
io_ft_tamp_hs_1v2 "io8_ft tamp high speed @ 1.2V"
io_ft_tamp_hs_1v8 "io8_ft tamp high speed @ 1.8V"
io_ft_tamp_hs_3v3 "io8_ft tamp high speed @ 3.3V"
[Model Selector] ioreset_v33
ioreset_v33_1v2 "Reset PAD. 5V tolerant. 1.2V range"
ioreset_v33_1v8 "Reset PAD. 5V tolerant. 1.8V range"
ioreset_v33_3v3 "Reset PAD. 5V tolerant. 3.3V range"
[Define Package Model]  4b0-ufqfpn-7x7-48-no-usb-240917
[Manufacturer]  Unknown
[OEM]  Unknown
[Description]  None
[Number Of Pins]  49
[Pin Numbers]
| Pin Num   Terminal Name
37 | RF
36 | NRST
13 | PA0
12 | PA1
10 | PA2
9 | PA5
7 | PA6
6 | PA7
5 | PA8
47 | PA9
46 | PA10
29 | PA11
28 | PA12
27 | PA13
26 | PA14
25 | PA15
32 | PB0
31 | PB1
30 | PB2
24 | PB3
23 | PB4
21 | PB5
20 | PB6
19 | PB7
15 | PB8
14 | PB9
4 | PB12
48 | PB14
33 | PB15
18 | PC13
17 | PC14-OSC32_IN
16 | PC15-OSC32_OUT
34 | PH3
39 | VDDANA
45 | VDD11
22 | VDD
35 | VDD
44 | VDD
8 | VDDA
38 | VDDHPA
11 | VDD
40 | VDDRF
43 | VDDRFPA
2 | VDDSMPS
3 | VLXSMPS
0 | VSS
1 | VSSSMPS
42 | OSC_IN
41 | OSC_OUT
[Model Data]
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[End Model Data]
[End Package Model]
|End [Component]
| Models and submodels in the file (69): io8_ft_100m_fs_1v2 (I/O), io8_ft_100m_fs_1v8 (I/O), io8_ft_100m_fs_3v3 (I/O), io8_ft_100m_hs_1v2 (I/O), io8_ft_100m_hs_1v8 (I/O), io8_ft_100m_hs_3v3 (I/O), io8_ft_100m_i2c_fmp_1v2 (I/O_open_drain), io8_ft_100m_i2c_fmp_1v8 (I/O_open_drain), io8_ft_100m_i2c_fmp_3v3 (I/O_open_drain), io8_ft_100m_i2c_fmp_v33_1v2 (I/O_open_drain), io8_ft_100m_i2c_fmp_v33_1v8 (I/O_open_drain), io8_ft_100m_i2c_fmp_v33_3v3 (I/O_open_drain), io8_ft_100m_i2c_fs_1v2 (I/O_open_drain), io8_ft_100m_i2c_fs_1v8 (I/O_open_drain), io8_ft_100m_i2c_fs_3v3 (I/O_open_drain), io8_ft_100m_i2c_hs_1v2 (I/O_open_drain), io8_ft_100m_i2c_hs_1v8 (I/O_open_drain), io8_ft_100m_i2c_hs_3v3 (I/O_open_drain), io8_ft_100m_i2c_ls_1v2 (I/O_open_drain), io8_ft_100m_i2c_ls_1v8 (I/O_open_drain), io8_ft_100m_i2c_ls_3v3 (I/O_open_drain), io8_ft_100m_i2c_ms_1v2 (I/O_open_drain), io8_ft_100m_i2c_ms_1v8 (I/O_open_drain), io8_ft_100m_i2c_ms_3v3 (I/O_open_drain), io8_ft_100m_i2c_v33_fs_1v2 (I/O_open_drain), io8_ft_100m_i2c_v33_fs_1v8 (I/O_open_drain), io8_ft_100m_i2c_v33_fs_3v3 (I/O_open_drain), io8_ft_100m_i2c_v33_hs_1v2 (I/O_open_drain), io8_ft_100m_i2c_v33_hs_1v8 (I/O_open_drain), io8_ft_100m_i2c_v33_hs_3v3 (I/O_open_drain), io8_ft_100m_i2c_v33_ls_1v2 (I/O_open_drain), io8_ft_100m_i2c_v33_ls_1v8 (I/O_open_drain), io8_ft_100m_i2c_v33_ls_3v3 (I/O_open_drain), io8_ft_100m_i2c_v33_ms_1v2 (I/O_open_drain), io8_ft_100m_i2c_v33_ms_1v8 (I/O_open_drain), io8_ft_100m_i2c_v33_ms_3v3 (I/O_open_drain), io8_ft_100m_ls_1v2 (I/O), io8_ft_100m_ls_1v8 (I/O), io8_ft_100m_ls_3v3 (I/O), io8_ft_100m_ms_1v2 (I/O), io8_ft_100m_ms_1v8 (I/O), io8_ft_100m_ms_3v3 (I/O), io8_ft_100m_v33_fs_1v2 (I/O), io8_ft_100m_v33_fs_1v8 (I/O), io8_ft_100m_v33_fs_3v3 (I/O), io8_ft_100m_v33_hs_1v2 (I/O), io8_ft_100m_v33_hs_1v8 (I/O), io8_ft_100m_v33_hs_3v3 (I/O), io8_ft_100m_v33_ls_1v2 (I/O), io8_ft_100m_v33_ls_1v8 (I/O), io8_ft_100m_v33_ls_3v3 (I/O), io8_ft_100m_v33_ms_1v2 (I/O), io8_ft_100m_v33_ms_1v8 (I/O), io8_ft_100m_v33_ms_3v3 (I/O), io_ft_tamp_fs_1v2 (I/O), io_ft_tamp_fs_1v8 (I/O), io_ft_tamp_fs_3v3 (I/O), io_ft_tamp_hs_1v2 (I/O), io_ft_tamp_hs_1v8 (I/O), io_ft_tamp_hs_3v3 (I/O), io_ft_tamp_ls_1v2 (I/O), io_ft_tamp_ls_1v8 (I/O), io_ft_tamp_ls_3v3 (I/O), io_ft_tamp_ms_1v2 (I/O), io_ft_tamp_ms_1v8 (I/O), io_ft_tamp_ms_3v3 (I/O), ioreset_v33_1v2 (I/O_open_drain), ioreset_v33_1v8 (I/O_open_drain), ioreset_v33_3v3 (I/O_open_drain)
